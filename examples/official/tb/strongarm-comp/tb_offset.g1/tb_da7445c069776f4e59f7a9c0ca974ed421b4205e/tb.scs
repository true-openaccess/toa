// Input-referred offset: a slow differential ramp, the comparator clocked at 100 MHz
simulator lang=spectre
parameters vdd=1.8
vdd (vdd 0) vsource dc=vdd
vclk (clk 0) vsource type=pulse val0=0 val1=vdd period=10n width=5n rise=50p fall=50p
vinp (inp 0) vsource type=pwl wave=[0 0.9-1m 1u 0.9+1m]
vinn (inn 0) vsource dc=0.9
dut (inp inn clk outp outn vdd 0) strongarm_comp
tran tran stop=1u
